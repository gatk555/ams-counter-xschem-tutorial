** sch_path: (generated from Xschem schematic current_mirror_cosim.sch)
**.subckt current_mirror_cosim
C23 count_out3 0 1f m=1
C22 count_out2 0 1f m=1
C21 count_out1 0 1f m=1
C20 count_out0 0 1f m=1
a1 [ CLK ] [ count_out3 count_out2 count_out1 count_out0 ] counter
V2 CLK 0 pulse 0 'VCC' 500n 10n 10n 490n 1u
XM1 Vg Vg 0 0 sg13_lv_nmos w=2u l=1u ng=1 m=1
I0 net1 Vg 10u
V1 net1 0 1.5
XM2 net3 Vg 0 0 sg13_lv_nmos w=2u l=1u ng=1 m=1
R5 net1 net2 0.1Meg m=1
VAMM2 net2 net3 0
XM3 net3 count_out0 net4 0 sg13_lv_nmos w=10u l=0.13u ng=1 m=1
XM4 net4 Vg 0 0 sg13_lv_nmos w=2u l=1u ng=1 m=1
XM5 net3 count_out1 net5 0 sg13_lv_nmos w=10u l=0.13u ng=1 m=1
XM6 net5 Vg 0 0 sg13_lv_nmos w=2u l=1u ng=1 m=1
XM7 net3 count_out2 net6 0 sg13_lv_nmos w=10u l=0.13u ng=1 m=1
XM8 net6 Vg 0 0 sg13_lv_nmos w=2u l=1u ng=1 m=1
XM9 net3 count_out3 net7 0 sg13_lv_nmos w=10u l=0.13u ng=1 m=1
XM10 net7 Vg 0 0 sg13_lv_nmos w=2u l=1u ng=1 m=1
**** begin user architecture code

.temp 27

.option method=gear
.param VCC=1.5

.control
save all
tran 0.1n 50u
*set wr_singlescale
*set wr_vecnames
*option numdgt=4
*plot i(Vmeas) i(Vmeas1)
remzerovec
write current_mirror_cosim.raw

.endc

 .lib cornerMOSlv.lib mos_tt

**** end user architecture code
**.ends
**** begin user architecture code
.model counter d_cosim simulation="ivlng" sim_args=["counter"] delay=0
**** end user architecture code
.end
